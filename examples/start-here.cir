* Start here: change R1 and watch the numbers move
V1 in 0 6
R1 in out 1k
R2 out 0 2k
.op
.end
