* Norton, example 3: R_N with .tf
* From the Solved Circuits video "Norton Equivalent and Source Transformation: 3 Solved Examples", https://youtu.be/ONxhzqlOw6M (CC BY 4.0)
Vin s 0 40
Vx s s2 0
R1 s2 n1 6
R2 n1 m 4
H1 0 m Vx 2
R3 n1 a 2
.tf v(a) Vin
* plainspice-drawing v1
*@ Vin 0 8 0 side=right
*@ Vx 2 0 270 side=above
*@ R1 13 0 270 side=above
*@ R2 15 4 0 side=right
*@ H1 15 11 180 side=right
*@ R3 23 0 270 side=above
*@ ground 15 15 0
*@ wire 0,0 0,6
*@ wire 4,0 11,0
*@ wire 15,2 15,0 21,0
*@ wire 25,0 31,0
*@ wire 15,6 15,9
*@ wire 0,10 0,15 15,15 15,13
*@ label s 0 0 side=above-left
*@ label s2 4 0 side=above-right
*@ label n1 15 1 side=right
*@ label m 15 8 side=left
*@ label a 31 0 side=above-right
.end
