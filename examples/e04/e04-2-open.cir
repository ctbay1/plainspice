* Norton, example 2: a and b open
* From the Solved Circuits video "Norton Equivalent and Source Transformation: 3 Solved Examples", https://youtu.be/ONxhzqlOw6M (CC BY 4.0)
V1 s 0 30
R1 s n1 5
R2 n1 0 20
R3 n1 a 8
I2 0 a 3
R4 a 0 4
.op
.end
