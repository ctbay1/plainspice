* Norton, example 2: a and b shorted (I_N)
* From the Solved Circuits video "Norton Equivalent and Source Transformation: 3 Solved Examples", https://youtu.be/ONxhzqlOw6M (CC BY 4.0)
V1 s 0 30
R1 s n1 5
R2 n1 0 20
R3 n1 a 8
I2 0 a 3
R4 a 0 4
Vshort a 0 0
.op
* plainspice-drawing v1
*@ V1 0 6 0 side=left
*@ R1 5 0 270 side=above
*@ R2 9 6 0 side=right
*@ R3 15 0 270 side=above
*@ I2 21 6 180 side=left
*@ R4 26 6 0 side=right
*@ Vshort 33 6 0 side=right
*@ ground 9 13 0
*@ wire 0,4 0,0 3,0
*@ wire 7,0 13,0
*@ wire 9,0 9,4
*@ wire 17,0 33,0 33,4
*@ wire 21,0 21,4
*@ wire 26,0 26,4
*@ wire 0,8 0,13 33,13 33,8
*@ wire 9,8 9,13
*@ wire 21,8 21,13
*@ wire 26,8 26,13
*@ label s 0 1 side=right
*@ label n1 9 2 side=above-right
*@ label a 30 0 side=above-right
.end
