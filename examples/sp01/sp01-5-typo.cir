* SPICE for Beginners, mistake 2: a typo in a node name
* From the Solved Circuits video "SPICE for Beginners: Check Any Circuit Answer with a Free Simulator (LTspice & ngspice)", https://youtu.be/eYtco4K4pm8 (CC BY 4.0)
V1 n1 0 6
R1 n1 n2 2
R2 n12 0 4
I1 0 n2 3
.op
* plainspice-drawing v1
*@ V1 0 8 0 side=left
*@ R1 9 0 270 side=above
*@ R2 17 8 0 side=right
*@ I1 27 8 180 side=right
*@ ground 17 15 0
*@ wire 0,6 0,0 7,0
*@ wire 11,0 27,0 27,6
*@ wire 17,6 17,3 20,3
*@ wire 0,10 0,15 27,15 27,10
*@ wire 17,10 17,15
*@ label n1 0 0 side=above-left
*@ label n2 18 0 side=above-left
*@ label n12 20 3 side=right
.end
