* SPICE for Beginners, example 1 with a 0 V ammeter
* From the Solved Circuits video "SPICE for Beginners: Check Any Circuit Answer with a Free Simulator (LTspice & ngspice)", https://youtu.be/eYtco4K4pm8 (CC BY 4.0)
V1 n1 0 6
R1 n1 n2 2
Vm n2 n2b 0
R2 n2b 0 4
I1 0 n2 3
.op
.end
