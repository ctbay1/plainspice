* SPICE for Beginners, mistake 1: no ground (node 0)
* From the Solved Circuits video "SPICE for Beginners: Check Any Circuit Answer with a Free Simulator (LTspice & ngspice)", https://youtu.be/eYtco4K4pm8 (CC BY 4.0)
V1 n1 n3 6
R1 n1 n2 2
R2 n2 n3 4
I1 n3 n2 3
.op
.end
