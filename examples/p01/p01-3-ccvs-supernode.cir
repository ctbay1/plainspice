* Nodal analysis, example 3: a supernode with a dependent source
* From the Solved Circuits video "Nodal Analysis with a Supernode: 3 Solved Examples (Easy to Exam Level)", https://youtu.be/7w-oSkPatcw (CC BY 4.0)
V1 n1 0 20
R2 n2 0 12
R3 n3 0 2
Rp n2 n3 5
Vsense n1 nx 0
R1 nx n2 4
H1 n2 n3 Vsense 5
.op
* plainspice-drawing v1
*@ V1 0 18 0 side=right
*@ R2 16 18 0 side=left
*@ R3 32 18 0 side=right
*@ Rp 24 0 270 side=above
*@ Vsense 2 9 270 side=above
*@ R1 13 9 270 side=below
*@ H1 24 9 270 side=above
*@ ground 16 27 0
*@ wire 16,16 16,0 22,0
*@ wire 26,0 32,0 32,16
*@ wire 0,9 0,16
*@ wire 4,9 11,9
*@ wire 15,9 16,9
*@ wire 16,9 22,9
*@ wire 26,9 32,9
*@ wire 0,20 0,27 32,27 32,20
*@ wire 16,20 16,27
*@ label n1 0 9 side=above-left
*@ label n2 16 11 side=above-right
*@ label n3 32 9 side=above-right
*@ label nx 4 9 side=below-right
.end
