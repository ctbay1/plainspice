* Nodal analysis, example 1: a source to ground
* From the Solved Circuits video "Nodal Analysis with a Supernode: 3 Solved Examples (Easy to Exam Level)", https://youtu.be/7w-oSkPatcw (CC BY 4.0)
V1 n1 0 6
R1 n1 n2 2
R2 n2 0 4
I1 0 n2 3
.op
* plainspice-drawing v1
*@ V1 0 5 0 side=left
*@ R1 5 0 270 side=above
*@ R2 9 5 0 side=right
*@ I1 16 5 180 side=right
*@ ground 9 9 0
*@ wire 0,3 0,0 3,0
*@ wire 7,0 16,0 16,3
*@ wire 9,0 9,3
*@ wire 0,7 0,9 16,9 16,7
*@ wire 9,7 9,9
*@ label n1 0 0 side=above-left
*@ label n2 9 0 side=above-right
.end
