* D1 (ours): a divider swept from 0 to 12 V with .dc
V1 in 0 0
R1 in out 1k
R2 out 0 2k
.dc V1 0 12 1
.end
