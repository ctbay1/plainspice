first-letter test [L]
Rref a 0 1
L1 a 0 5
.op
.end
