first-letter test [T]
Rref a 0 1
T1 a 0 5
.op
.end
