first-letter test [9]
Rref a 0 1
91 a 0 5
.op
.end
