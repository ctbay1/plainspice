first-letter test [Q]
Rref a 0 1
Q1 a 0 5
.op
.end
