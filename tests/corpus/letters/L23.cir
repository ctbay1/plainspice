first-letter test [X]
Rref a 0 1
X1 a 0 5
.op
.end
