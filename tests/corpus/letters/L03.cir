first-letter test [D]
Rref a 0 1
D1 a 0 5
.op
.end
