first-letter test [O]
Rref a 0 1
O1 a 0 5
.op
.end
