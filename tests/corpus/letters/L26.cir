first-letter test [0]
Rref a 0 1
01 a 0 5
.op
.end
