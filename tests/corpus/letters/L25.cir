first-letter test [Z]
Rref a 0 1
Z1 a 0 5
.op
.end
