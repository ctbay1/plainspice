first-letter test [Y]
Rref a 0 1
Y1 a 0 5
.op
.end
