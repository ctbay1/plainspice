first-letter test [U]
Rref a 0 1
U1 a 0 5
.op
.end
