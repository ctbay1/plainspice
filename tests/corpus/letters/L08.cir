first-letter test [I]
Rref a 0 1
I1 a 0 5
.op
.end
