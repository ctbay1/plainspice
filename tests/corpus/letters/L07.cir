first-letter test [H]
Rref a 0 1
H1 a 0 5
.op
.end
