first-letter test [G]
Rref a 0 1
G1 a 0 5
.op
.end
