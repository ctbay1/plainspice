first-letter test [_]
Rref a 0 1
_1 a 0 5
.op
.end
