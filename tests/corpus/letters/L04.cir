first-letter test [E]
Rref a 0 1
E1 a 0 5
.op
.end
