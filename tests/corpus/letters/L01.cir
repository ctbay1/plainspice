first-letter test [B]
Rref a 0 1
B1 a 0 5
.op
.end
