first-letter test [1]
Rref a 0 1
11 a 0 5
.op
.end
