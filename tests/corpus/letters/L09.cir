first-letter test [J]
Rref a 0 1
J1 a 0 5
.op
.end
