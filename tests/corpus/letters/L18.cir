first-letter test [S]
Rref a 0 1
S1 a 0 5
.op
.end
