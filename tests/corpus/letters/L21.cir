first-letter test [V]
Rref a 0 1
V1 a 0 5
.op
.end
