first-letter test [K]
Rref a 0 1
K1 a 0 5
.op
.end
