first-letter test [W]
Rref a 0 1
W1 a 0 5
.op
.end
