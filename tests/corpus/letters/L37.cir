first-letter test [&]
Rref a 0 1
&1 a 0 5
.op
.end
