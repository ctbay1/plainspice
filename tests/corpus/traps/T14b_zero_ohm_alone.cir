T14b: a 0 ohm resistor straight across a voltage source
V1 a 0 6
R1 a 0 0
.op
.end
