T11a: no .end line
V1 n1 0 6
R1 n1 0 2
.op
