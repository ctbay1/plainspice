T15b: a node connected only to capacitors, with a resistor elsewhere
V1 a 0 6
R1 a c 1k
C1 c b 1u
C2 b 0 2u
R2 c 0 1k
.op
.end
