T20e: .dc sweeping a source that does not exist
V1 in 0 0
R1 in out 1k
R2 out 0 2k
C1 out 0 1u
.dc V9 0 12 1
.end
