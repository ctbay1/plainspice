T21d: .tran with tstart after tstop
V1 in 0 0
R1 in out 1k
R2 out 0 2k
C1 out 0 1u
.tran 10u 5m 6m
.end
