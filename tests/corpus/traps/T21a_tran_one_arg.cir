T21a: .tran with one argument
V1 in 0 0
R1 in out 1k
R2 out 0 2k
C1 out 0 1u
.tran 5m
.end
