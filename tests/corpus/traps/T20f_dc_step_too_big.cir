T20f: .dc step larger than the range
V1 in 0 0
R1 in out 1k
R2 out 0 2k
C1 out 0 1u
.dc V1 0 12 20
.end
