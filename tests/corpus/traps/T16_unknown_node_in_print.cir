T16: .print of a node that does not exist (with .dc)
V1 a 0 0
R1 a 0 1k
.dc V1 0 1 1
.print dc v(b)
.end
