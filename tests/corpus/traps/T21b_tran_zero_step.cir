T21b: .tran with a zero step
V1 in 0 0
R1 in out 1k
R2 out 0 2k
C1 out 0 1u
.tran 0 5m
.end
